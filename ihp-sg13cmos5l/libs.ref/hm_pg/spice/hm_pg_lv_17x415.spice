.subckt hm_pg_lv_17x415 VPWR GPWR GND CTRL
XM1 ctrl_n ctrl GND GND sg13_lv_nmos w=4u l=0.13u ng=1 m=1 mm_ok=1
XM2 ctrl_n ctrl VPWR VPWR sg13_lv_pmos w=8u l=0.13u ng=1 m=1 mm_ok=1
XM3 GPWR ctrl_n VPWR VPWR sg13_lv_pmos w=5517.3u l=0.13u ng=795 m=2 mm_ok=1
x1 GND GPWR ctrl_n dischg
.ends

.subckt dischg GND GPWR gate
XM1 GPWR gate net1 GND sg13_lv_nmos w=1u l=0.65u ng=1 m=1 mm_ok=1
XM2 net1 gate net2 GND sg13_lv_nmos w=1u l=0.65u ng=1 m=1 mm_ok=1
XM3 net2 gate net3 GND sg13_lv_nmos w=1u l=0.65u ng=1 m=1 mm_ok=1
XM4 net3 gate net4 GND sg13_lv_nmos w=1u l=0.65u ng=1 m=1 mm_ok=1
XM5 net4 gate net5 GND sg13_lv_nmos w=1u l=0.65u ng=1 m=1 mm_ok=1
XM6 net5 gate net6 GND sg13_lv_nmos w=1u l=0.65u ng=1 m=1 mm_ok=1
XM7 net6 gate net7 GND sg13_lv_nmos w=1u l=0.65u ng=1 m=1 mm_ok=1
XM8 net7 gate GND GND sg13_lv_nmos w=1u l=0.65u ng=1 m=1 mm_ok=1

XM9 GPWR gate net8 GND sg13_lv_nmos w=1u l=0.65u ng=1 m=1 mm_ok=1
XM10 net8 gate net9 GND sg13_lv_nmos w=1u l=0.65u ng=1 m=1 mm_ok=1
XM11 net9 gate net10 GND sg13_lv_nmos w=1u l=0.65u ng=1 m=1 mm_ok=1
XM12 net10 gate net11 GND sg13_lv_nmos w=1u l=0.65u ng=1 m=1 mm_ok=1
XM13 net11 gate net12 GND sg13_lv_nmos w=1u l=0.65u ng=1 m=1 mm_ok=1
XM14 net12 gate net13 GND sg13_lv_nmos w=1u l=0.65u ng=1 m=1 mm_ok=1
XM15 net13 gate net14 GND sg13_lv_nmos w=1u l=0.65u ng=1 m=1 mm_ok=1
XM16 net14 gate GND GND sg13_lv_nmos w=1u l=0.65u ng=1 m=1 mm_ok=1
.ends

.end
