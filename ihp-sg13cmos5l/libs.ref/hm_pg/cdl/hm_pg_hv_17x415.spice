.subckt hm_pg_hv_17x415 GPWR VAPWR VDPWR CTRL GND
x2 VAPWR VDPWR ctrl H_crtl_p H_crtl_n GND lv2hv
M4 ctrl_n H_crtl_p GND GND sg13_hv_nmos w=4u l=0.45u ng=1 m=1 mm_ok=1
M5 ctrl_n H_crtl_p VAPWR VAPWR sg13_hv_pmos w=8u l=0.45u ng=1 m=1 mm_ok=1
M1 GPWR ctrl_n VAPWR VAPWR sg13_hv_pmos w=3368.04u l=0.4u ng=508 m=2 mm_ok=1
x3 GND GPWR ctrl_n hv_dischg
.ends

.subckt lv2hv VAPWR VDPWR in out_p out_n GND
M1 in_n in GND GND sg13_lv_nmos w=1u l=0.13u ng=1 m=1 mm_ok=1
M2 in_n in VDPWR VDPWR sg13_lv_pmos w=2u l=0.13u ng=1 m=1 mm_ok=1
M3 in_p in_n GND GND sg13_lv_nmos w=1u l=0.13u ng=1 m=1 mm_ok=1
M4 in_p in_n VDPWR VDPWR sg13_lv_pmos w=2u l=0.13u ng=1 m=1 mm_ok=1
M5 out_p net1 GND GND sg13_hv_nmos w=1u l=0.45u ng=1 m=1 mm_ok=1
M6 net1 in_p GND GND sg13_hv_nmos w=3.2u l=0.45u ng=1 m=1 mm_ok=1
M7 out_p net1 VAPWR VAPWR sg13_hv_pmos w=2u l=0.45u ng=1 m=1 mm_ok=1
M8 net1 net2 VAPWR VAPWR sg13_hv_pmos w=1u l=0.45u ng=1 m=1 mm_ok=1
M9 net2 net1 VAPWR VAPWR sg13_hv_pmos w=1u l=0.45u ng=1 m=1 mm_ok=1
M10 net2 in_n GND GND sg13_hv_nmos w=3.2u l=0.45u ng=1 m=1 mm_ok=1
M11 out_n net2 GND GND sg13_hv_nmos w=1u l=0.45u ng=1 m=1 mm_ok=1
M12 out_n net2 VAPWR VAPWR sg13_hv_pmos w=2u l=0.45u ng=1 m=1 mm_ok=1
.ends

.subckt hv_dischg GND GPWR gate
M1 GPWR gate net1 GND sg13_hv_nmos w=1u l=0.65u ng=1 m=1 mm_ok=1
M2 net1 gate net2 GND sg13_hv_nmos w=1u l=0.65u ng=1 m=1 mm_ok=1
M3 net2 gate net3 GND sg13_hv_nmos w=1u l=0.65u ng=1 m=1 mm_ok=1
M4 net3 gate net4 GND sg13_hv_nmos w=1u l=0.65u ng=1 m=1 mm_ok=1
M5 net4 gate net5 GND sg13_hv_nmos w=1u l=0.65u ng=1 m=1 mm_ok=1
M6 net5 gate net6 GND sg13_hv_nmos w=1u l=0.65u ng=1 m=1 mm_ok=1
M7 net6 gate GND GND sg13_hv_nmos w=1u l=0.65u ng=1 m=1 mm_ok=1

M8 GPWR gate net7 GND sg13_hv_nmos w=1u l=0.65u ng=1 m=1 mm_ok=1
M9 net7 gate net8 GND sg13_hv_nmos w=1u l=0.65u ng=1 m=1 mm_ok=1
M10 net8 gate net9 GND sg13_hv_nmos w=1u l=0.65u ng=1 m=1 mm_ok=1
M11 net9 gate net10 GND sg13_hv_nmos w=1u l=0.65u ng=1 m=1 mm_ok=1
M12 net10 gate net11 GND sg13_hv_nmos w=1u l=0.65u ng=1 m=1 mm_ok=1
M13 net11 gate net12 GND sg13_hv_nmos w=1u l=0.65u ng=1 m=1 mm_ok=1
M14 net12 gate GND GND sg13_hv_nmos w=1u l=0.65u ng=1 m=1 mm_ok=1
.ends

.end
