.subckt hm_pg_lv_17x200 VPWR GPWR GND CTRL
M1 ctrl_n ctrl GND GND sg13_lv_nmos w=4u l=0.13u ng=1 m=1 mm_ok=1
M2 ctrl_n ctrl VPWR VPWR sg13_lv_pmos w=8u l=0.13u ng=1 m=1 mm_ok=1
M3 GPWR ctrl_n VPWR VPWR sg13_lv_pmos w=2588.62u l=0.13u ng=373 m=2 mm_ok=1
x1 GND GPWR ctrl_n dischg
.ends

.subckt dischg GND GPWR gate
M1 GPWR gate net1 GND sg13_lv_nmos w=1u l=0.65u ng=1 m=1 mm_ok=1
M2 net1 gate net2 GND sg13_lv_nmos w=1u l=0.65u ng=1 m=1 mm_ok=1
M3 net2 gate net3 GND sg13_lv_nmos w=1u l=0.65u ng=1 m=1 mm_ok=1
M4 net3 gate net4 GND sg13_lv_nmos w=1u l=0.65u ng=1 m=1 mm_ok=1
M5 net4 gate net5 GND sg13_lv_nmos w=1u l=0.65u ng=1 m=1 mm_ok=1
M6 net5 gate net6 GND sg13_lv_nmos w=1u l=0.65u ng=1 m=1 mm_ok=1
M7 net6 gate net7 GND sg13_lv_nmos w=1u l=0.65u ng=1 m=1 mm_ok=1
M8 net7 gate GND GND sg13_lv_nmos w=1u l=0.65u ng=1 m=1 mm_ok=1

M9 GPWR gate net8 GND sg13_lv_nmos w=1u l=0.65u ng=1 m=1 mm_ok=1
M10 net8 gate net9 GND sg13_lv_nmos w=1u l=0.65u ng=1 m=1 mm_ok=1
M11 net9 gate net10 GND sg13_lv_nmos w=1u l=0.65u ng=1 m=1 mm_ok=1
M12 net10 gate net11 GND sg13_lv_nmos w=1u l=0.65u ng=1 m=1 mm_ok=1
M13 net11 gate net12 GND sg13_lv_nmos w=1u l=0.65u ng=1 m=1 mm_ok=1
M14 net12 gate net13 GND sg13_lv_nmos w=1u l=0.65u ng=1 m=1 mm_ok=1
M15 net13 gate net14 GND sg13_lv_nmos w=1u l=0.65u ng=1 m=1 mm_ok=1
M16 net14 gate GND GND sg13_lv_nmos w=1u l=0.65u ng=1 m=1 mm_ok=1
.ends

.end
